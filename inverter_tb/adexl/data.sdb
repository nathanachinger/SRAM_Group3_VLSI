ADE simulation setup
Run mode: Single Run, Sweeps and Corners
Tests:
  SRAM_Group3_VLSI:inverter_tb:1: SRAM_Group3_VLSI/inverter_tb/schematic, simulator spectre
